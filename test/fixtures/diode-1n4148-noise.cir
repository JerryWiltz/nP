1N4148 archived NXP diode independent reference
* Modified: 2026-11-15
.temp 27
.options gmin=1e-15 abstol=1e-15 reltol=1e-10
.model device D (IS=4.352e-9 N=1.906 BV=110 IBV=0.0001 RS=0.6458 CJO=7.048e-13 VJ=0.869 M=0.03 FC=0.5 TT=3.48e-9 EG=1.11 XTI=3 NBV=1 KF=0 AF=1)
D1 a k device
Rleak a k 5.827e9
Vbias supply 0 DC 0.6
Lbias supply a 1e3
Lreturn k 0 1e3
Rsource input aca 50
Vsignal input 0 DC 0 AC 1
Ca aca a 1e-3
Ck k load 1e-3
Gload load 0 load 0 0.02
.control
set numdgt=15
set wr_vecnames
set wr_singlescale
noise v(load) Vsignal dec 1 10meg 1g
setplot noise1
wrdata diode-noise.txt inoise_spectrum onoise_spectrum
quit
.endc
.end
