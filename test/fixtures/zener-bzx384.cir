BZX384-B4V7 archived single-junction reference
* Modified: 2026-11-22
* Archived NXP/Philips card; see zenerModels.md for provenance and limitations.
.temp 27
.options gmin=1e-24 abstol=1e-18 reltol=1e-10
.model device D(IS=1.033e-15 N=1.001 BV=4.7 IBV=.005 RS=.387 CJO=2.589e-10 VJ=.8029 M=.3636 FC=.5 TT=0 EG=1.11 XTI=3 TNOM=27 NBV=1 KF=0 AF=1)
D1 a k device
Vbias supply 0 DC -4.7
Lbias supply a 1e3
Lreturn k 0 1e3
Ra aca 0 50
Rk ack 0 50
Ca aca a 1e-3
Ck ack k 1e-3
Ia 0 aca DC 0 AC 1
Ik 0 ack DC 0 AC 0
Vfeed feed 0 -8
Rnet feed net 2000
Dnet net 0 device
.control
set numdgt=15
set wr_vecnames
set wr_singlescale
set temp=27
alter Vbias = -2
op
wrdata /tmp/zener-27-0-op.txt v(a) v(k) @d1[id] @d1[gd] v(net) @dnet[id]
alter @Ia[acmag] = 1
alter @Ik[acmag] = 0
ac dec 1 1meg 1g
wrdata /tmp/zener-27-0-p1.txt v(aca) v(ack)
alter @Ia[acmag] = 0
alter @Ik[acmag] = 1
ac dec 1 1meg 1g
wrdata /tmp/zener-27-0-p2.txt v(aca) v(ack)
set temp=27
alter Vbias = -4.6
op
wrdata /tmp/zener-27-1-op.txt v(a) v(k) @d1[id] @d1[gd] v(net) @dnet[id]
alter @Ia[acmag] = 1
alter @Ik[acmag] = 0
ac dec 1 1meg 1g
wrdata /tmp/zener-27-1-p1.txt v(aca) v(ack)
alter @Ia[acmag] = 0
alter @Ik[acmag] = 1
ac dec 1 1meg 1g
wrdata /tmp/zener-27-1-p2.txt v(aca) v(ack)
set temp=27
alter Vbias = -4.7
op
wrdata /tmp/zener-27-2-op.txt v(a) v(k) @d1[id] @d1[gd] v(net) @dnet[id]
alter @Ia[acmag] = 1
alter @Ik[acmag] = 0
ac dec 1 1meg 1g
wrdata /tmp/zener-27-2-p1.txt v(aca) v(ack)
alter @Ia[acmag] = 0
alter @Ik[acmag] = 1
ac dec 1 1meg 1g
wrdata /tmp/zener-27-2-p2.txt v(aca) v(ack)
set temp=27
alter Vbias = -4.8
op
wrdata /tmp/zener-27-3-op.txt v(a) v(k) @d1[id] @d1[gd] v(net) @dnet[id]
alter @Ia[acmag] = 1
alter @Ik[acmag] = 0
ac dec 1 1meg 1g
wrdata /tmp/zener-27-3-p1.txt v(aca) v(ack)
alter @Ia[acmag] = 0
alter @Ik[acmag] = 1
ac dec 1 1meg 1g
wrdata /tmp/zener-27-3-p2.txt v(aca) v(ack)
set temp=27
alter Vbias = 0.6
op
wrdata /tmp/zener-27-4-op.txt v(a) v(k) @d1[id] @d1[gd] v(net) @dnet[id]
alter @Ia[acmag] = 1
alter @Ik[acmag] = 0
ac dec 1 1meg 1g
wrdata /tmp/zener-27-4-p1.txt v(aca) v(ack)
alter @Ia[acmag] = 0
alter @Ik[acmag] = 1
ac dec 1 1meg 1g
wrdata /tmp/zener-27-4-p2.txt v(aca) v(ack)
set temp=65
alter Vbias = -2
op
wrdata /tmp/zener-65-0-op.txt v(a) v(k) @d1[id] @d1[gd] v(net) @dnet[id]
alter @Ia[acmag] = 1
alter @Ik[acmag] = 0
ac dec 1 1meg 1g
wrdata /tmp/zener-65-0-p1.txt v(aca) v(ack)
alter @Ia[acmag] = 0
alter @Ik[acmag] = 1
ac dec 1 1meg 1g
wrdata /tmp/zener-65-0-p2.txt v(aca) v(ack)
set temp=65
alter Vbias = -4.6
op
wrdata /tmp/zener-65-1-op.txt v(a) v(k) @d1[id] @d1[gd] v(net) @dnet[id]
alter @Ia[acmag] = 1
alter @Ik[acmag] = 0
ac dec 1 1meg 1g
wrdata /tmp/zener-65-1-p1.txt v(aca) v(ack)
alter @Ia[acmag] = 0
alter @Ik[acmag] = 1
ac dec 1 1meg 1g
wrdata /tmp/zener-65-1-p2.txt v(aca) v(ack)
set temp=65
alter Vbias = -4.7
op
wrdata /tmp/zener-65-2-op.txt v(a) v(k) @d1[id] @d1[gd] v(net) @dnet[id]
alter @Ia[acmag] = 1
alter @Ik[acmag] = 0
ac dec 1 1meg 1g
wrdata /tmp/zener-65-2-p1.txt v(aca) v(ack)
alter @Ia[acmag] = 0
alter @Ik[acmag] = 1
ac dec 1 1meg 1g
wrdata /tmp/zener-65-2-p2.txt v(aca) v(ack)
set temp=65
alter Vbias = -4.8
op
wrdata /tmp/zener-65-3-op.txt v(a) v(k) @d1[id] @d1[gd] v(net) @dnet[id]
alter @Ia[acmag] = 1
alter @Ik[acmag] = 0
ac dec 1 1meg 1g
wrdata /tmp/zener-65-3-p1.txt v(aca) v(ack)
alter @Ia[acmag] = 0
alter @Ik[acmag] = 1
ac dec 1 1meg 1g
wrdata /tmp/zener-65-3-p2.txt v(aca) v(ack)
set temp=65
alter Vbias = 0.6
op
wrdata /tmp/zener-65-4-op.txt v(a) v(k) @d1[id] @d1[gd] v(net) @dnet[id]
alter @Ia[acmag] = 1
alter @Ik[acmag] = 0
ac dec 1 1meg 1g
wrdata /tmp/zener-65-4-p1.txt v(aca) v(ack)
alter @Ia[acmag] = 0
alter @Ik[acmag] = 1
ac dec 1 1meg 1g
wrdata /tmp/zener-65-4-p2.txt v(aca) v(ack)
quit
.endc
.end
