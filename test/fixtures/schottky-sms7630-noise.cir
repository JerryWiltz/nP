Skyworks SMS7630 per-junction independent reference
* Modified: 2026-11-21
* Skyworks 200041AH Table 5; package L/C excluded. Classical SPICE defaults explicit.
.temp 27
.options gmin=1e-18 abstol=1e-15 reltol=1e-10
.model device D (IS=5e-6 RS=20 N=1.05 TT=1e-11 CJO=.14p M=.40 EG=.69 XTI=2 FC=.5 BV=2 IBV=1e-4 VJ=.34 TNOM=27 NBV=1 KF=0 AF=1)
D1 a k device
Vbias supply 0 DC 0.05
Lbias supply a 1e3
Lreturn k 0 1e3
Rsource input aca 50
Vsignal input 0 DC 0 AC 1
Ca aca a 1e-3
Ck k load 1e-3
Gload load 0 load 0 0.02
.control
set numdgt=15
set wr_vecnames
set wr_singlescale
noise v(load) Vsignal dec 1 10meg 1g
setplot noise1
wrdata schottky-sms7630-noise.txt inoise_spectrum onoise_spectrum
quit
.endc
.end
