Full charge-storage PIN independent reference
* Modified: 2026-11-22
* ADS Nonlinear Devices 2019 pp 361-367, five-section RC storage, level 1.
* Numerical supplied record, not a manufacturer-fit device.
.temp 25
.options reltol=1e-8 abstol=1e-14 vntol=1e-9 gmin=1e-18 itl1=1000 gshunt=1e-14 tnom=25
.model junction D(IS=1e-10 N=1 RS=1 IKF=0.01)
.subckt pin a k
Cpack a k 8e-14
Lbond a core 1e-9
Rp core k 100000000.0
Cj core k 2e-13
Repi core j 1000
Rlim core m 2
Bmod m j I=(v(x0,x1)+sqrt(v(x0,x1)^2+4e-24))*v(m,j)/0.040000000000000015
Fpin j k Vlad 1
Ej drive 0 j k 1
Vpn drive dj1 0
Dpi dj1 dj2 junction
Din dj2 0 junction
Hdrive sx 0 Vpn 1
Vlad sx x0 0
Bge x0 0 I=0.25*(v(x0)+sqrt(v(x0)^2+4e-24))^2/0.02
RP1 x0 x1 1 noisy=0
CP1 x0 x1 1e-07
RS1 x1 0 2.756244616709733 noisy=0
RP2 x1 x2 5 noisy=0
CP2 x1 x2 2e-08
RS2 x2 0 1.1812476928756 noisy=0
RP3 x2 x3 9 noisy=0
CP3 x2 x3 1.111111111111111e-08
RS3 x3 0 0.7517030772844727 noisy=0
RP4 x3 x4 13 noisy=0
CP4 x3 x4 7.692307692307693e-09
RS4 x4 0 0.5512489233419466 noisy=0
RP5 x4 x5 17 noisy=0
CP5 x4 x5 5.88235294117647e-09
RS5 x5 0 0.4351965184278526 noisy=0
.ends
Vsource src 0 DC 0 AC 1
Rsource src a 50
Gload k 0 k 0 .02
Xpin a k pin
Vcal ci 0 DC 0 AC 1
Rcal ci co 50

Gcal co 0 co 0 .02
.control
set numdgt=15
set wr_singlescale
set wr_vecnames
alter Vsource DC 0
op
wrdata /tmp/full-pin-dc-0.txt v(a) v(k) i(Vsource) v(xpin.j) v(xpin.x0,xpin.x1) i(v.xpin.vpn)
ac dec 1 1e3 1e9
wrdata /tmp/full-pin-ac-0.txt v(a) v(k)
noise v(k) Vsource dec 1 1e3 1e9
setplot noise1
wrdata /tmp/full-pin-noise-0.txt onoise_spectrum
alter Vsource DC 1
op
wrdata /tmp/full-pin-dc-1.txt v(a) v(k) i(Vsource) v(xpin.j) v(xpin.x0,xpin.x1) i(v.xpin.vpn)
ac dec 1 1e3 1e9
wrdata /tmp/full-pin-ac-1.txt v(a) v(k)
noise v(k) Vsource dec 1 1e3 1e9
setplot noise3
wrdata /tmp/full-pin-noise-1.txt onoise_spectrum
alter Vsource DC 1.5
op
wrdata /tmp/full-pin-dc-2.txt v(a) v(k) i(Vsource) v(xpin.j) v(xpin.x0,xpin.x1) i(v.xpin.vpn)
ac dec 1 1e3 1e9
wrdata /tmp/full-pin-ac-2.txt v(a) v(k)
noise v(k) Vsource dec 1 1e3 1e9
setplot noise5
wrdata /tmp/full-pin-noise-2.txt onoise_spectrum
alter Vsource DC -5
op
wrdata /tmp/full-pin-dc-3.txt v(a) v(k) i(Vsource) v(xpin.j) v(xpin.x0,xpin.x1) i(v.xpin.vpn)
ac dec 1 1e3 1e9
wrdata /tmp/full-pin-ac-3.txt v(a) v(k)
noise v(k) Vsource dec 1 1e3 1e9
setplot noise7
wrdata /tmp/full-pin-noise-3.txt onoise_spectrum
noise v(co) Vcal lin 1 1e6 1e6
wrdata /tmp/full-pin-cal.txt onoise_spectrum
quit
.endc
.end
